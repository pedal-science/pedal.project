* phantom
VSUP sup 0 DC 9
R40 sup v9f 100
C20 v9f 0 100u
C21 v9f 0 100n
R38 v9f vref 47k
R39 vref 0 47k
C19 vref 0 100u
VHP hpl 0 DC 1.65 AC 1
C16 hpl cin 10u
R28 cin tap 9.1k
R29 tap vref 1k
SLINE padcom cin linectl 0 PADSW
SMIC padcom tap micctl 0 PADSW
VLINE linectl 0 {1-(0)}
VMIC micctl 0 {0}
R30 padcom x 1k
R31 x vref 100k
SMUTE x vref mutectl 0 RELAY
VMUTE mutectl 0 0
XU5A x aout aout v9f 0 OPAMP_OPA2197
R32 aout invn 10k
R33 invn bout 10k
XU5B vref invn bout v9f 0 OPAMP_OPA2197
R34 aout h 100
C17 h hc 47u Rser=0.5
R41 hc hot 10
D8 h v9f DSCH
D9 0 h DSCH
R36 hot 0 100k
R35 bout cn 100
C18 cn cc 47u Rser=0.5
R42 cc cold 10
D10 cn v9f DSCH
D11 0 cn DSCH
R37 cold 0 100k
VPH p48 0 PWL(0 0 1 0 1.0001 48)
RPH hot p48 6.81k
RPC cold p48 6.81k
SSHORT hot 0 shortctl 0 RELAY
VSHORT shortctl 0 PWL(0 0 3 0 3.0001 1 3.01 1 3.0101 0)
.meas TRAN hot_dc FIND V(hot) AT 2.9
.meas TRAN h_max MAX V(h) FROM 0.9 TO 4
.meas TRAN h_min MIN V(h) FROM 0.9 TO 4
.meas TRAN id9_peak MAX I(D9) FROM 2.99 TO 3.02
.meas TRAN id8_peak MAX I(D8) FROM 0.9 TO 4
.meas TRAN iop_peak MAX abs(I(R34)) FROM 0.9 TO 4
.meas TRAN id9_charge INTEG I(D9) FROM 2.999 TO 3.01
* Generated by kicad-happy's spice_model_generator.generate_opamp_model('OPA2197', ...)
.subckt OPAMP_OPA2197 inp inn out vcc vee
Rin inp inn 10T
Vos inp inp_os DC 2.5e-05
E1 int 0 inp_os inn 10000000
R1 int out_int 1
C1 out_int 0 159.2m
Dhigh out_int vcc_int DLIMIT
Dlow vee_int out_int DLIMIT
Vswh vcc vcc_int DC 0
Vswl vee_int vee DC 0
.model DLIMIT D(IS=1e-14 N=0.01)
Eout out 0 out_int 0 1
.ends OPAMP_OPA2197
.model DSCH D(Is=31.7u Rs=.051 N=1.373 Cjo=190p M=.3 Eg=.69 Xti=2 BV=20 IBV=1m)
.model RELAY SW(Ron=.025 Roff=1G Vt=.5 Vh=0)
.model PADSW SW(Ron=.05 Roff=1G Vt=.5 Vh=0)
.tran 0 4 0 100u
.options plotwinsize=0
.end
