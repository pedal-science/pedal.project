* powerup
VSUP sup 0 PWL(0 0 1m 9)
R40 sup v9f 100
C20 v9f 0 100u
C21 v9f 0 100n
R38 v9f vref 47k
R39 vref 0 47k
C19 vref 0 100u
VHP hplb 0 PWL(0 0 1 0 1.5 1.65 20 1.65)
VSIG hpl hplb SINE(0 1.26 1k 20)
C16 hpl cin 10u
R28 cin tap 9.1k
R29 tap vref 1k
SLINE padcom cin linectl 0 PADSW
SMIC padcom tap micctl 0 PADSW
VLINE linectl 0 {1-(0)}
VMIC micctl 0 {0}
R30 padcom x 1k
R31 x vref 100k
SMUTE x vref mutectl 0 RELAY
VMUTE mutectl 0 PWL(0 1 15 1 15.001 0)
XU5A x aout aout v9f 0 OPAMP_OPA2197
R32 aout invn 10k
R33 invn bout 10k
XU5B vref invn bout v9f 0 OPAMP_OPA2197
R34 aout h 100
C17 h hc 47u Rser=0.5
R41 hc hot 10
D8 h v9f DSCH
D9 0 h DSCH
R36 hot 0 100k
R35 bout cn 100
C18 cn cc 47u Rser=0.5
R42 cc cold 10
D10 cn v9f DSCH
D11 0 cn DSCH
R37 cold 0 100k
RRH hot 0 10k
RRC cold 0 10k
.meas TRAN thump_boot MAX abs(V(hot,cold)) FROM 0 TO 14.9
.meas TRAN cm_boot MAX abs(V(hot)+V(cold))/2 FROM 0 TO 14.9
.meas TRAN thump_release MAX abs(V(hot,cold)) FROM 14.99 TO 19.99
.meas TRAN sig_pp PP V(hot,cold) FROM 20.01 TO 20.02
.meas TRAN hot_pp PP V(hot) FROM 20.01 TO 20.02
.meas TRAN cold_pp PP V(cold) FROM 20.01 TO 20.02
* Generated by kicad-happy's spice_model_generator.generate_opamp_model('OPA2197', ...)
.subckt OPAMP_OPA2197 inp inn out vcc vee
Rin inp inn 10T
Vos inp inp_os DC 2.5e-05
E1 int 0 inp_os inn 10000000
R1 int out_int 1
C1 out_int 0 159.2m
Dhigh out_int vcc_int DLIMIT
Dlow vee_int out_int DLIMIT
Vswh vcc vcc_int DC 0
Vswl vee_int vee DC 0
.model DLIMIT D(IS=1e-14 N=0.01)
Eout out 0 out_int 0 1
.ends OPAMP_OPA2197
.model DSCH D(Is=31.7u Rs=.051 N=1.373 Cjo=190p M=.3 Eg=.69 Xti=2 BV=20 IBV=1m)
.model RELAY SW(Ron=.025 Roff=1G Vt=.5 Vh=0)
.model PADSW SW(Ron=.05 Roff=1G Vt=.5 Vh=0)
.tran 0 20.02 0 1m
.options plotwinsize=0
.end
